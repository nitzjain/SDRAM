|   Analog Devices INC.
|   IBIS Model of BF606/BF607/BF608/BF609
|   Embedded processor
|   349 ball 19x19 LFBGA
[IBIS ver]   3.2
[File name]   bf606_19x19.ibs
[File Rev]   1.0
[Date]   Thu Jun  7 14:16:01 IST 2012
[Source]   Simulation on HSPICE
[Notes]
|   No models exist for the following pins
|   ( Using type NC as a placeholder ):
|   USB0_DP,USB0_DM,USB0_CLKIN, USB0_VBC,USB0_ID,
|   USB0_VBUS,SYS_CLKIN,SYS_XTAL,SYS_TDK,SYS_TDA
|This IBIS model is generated automatically using script chip_ibis_model_gen.pl
[Disclaimer]
|   This IBIS model is provided "AS IS, WHERE IS",
|   AND WITH NO WARRANTY OF ANY KIND EITHER EXPRESSED
|   OR IMPLIED, INCLUDING BUT NOT LIMITED TO
[Copyright]   ADI
[Component]   BF606/BF607/BF608/BF609
[Manufacturer] ADI
[Package]
|  variable   typ   min   max
R_pkg   347.557m   165.01m   503.68m
L_pkg   3.541705nH   1.69nH   4.99nH
C_pkg   1.053088pf   0.71pf   5.11pf
[Pin]   signal_name   model_name   R_pin   L_pin   C_pin
A01   GND   gnd   NA   NA   NA
A02   USB0_DM   NC   NA   NA   NA
A03   USB0_DP   NC   NA   NA   NA
A04   PB_10   pad_gpio_3p3_3v   NA   NA   NA
A05   PB_07   pad_gpio_3p3_3v   NA   NA   NA
A06   PA_14   pad_gpio_3p3_3v   NA   NA   NA
A07   PA_12   pad_gpio_3p3_3v   NA   NA   NA
A08   PA_10   pad_gpio_3p3_3v   NA   NA   NA
A09   PA_08   pad_gpio_3p3_3v   NA   NA   NA
A10   PA_06   pad_gpio_3p3_3v   NA   NA   NA
A11   PA_04   pad_gpio_3p3_3v   NA   NA   NA
A12   PA_02   pad_gpio_3p3_3v   NA   NA   NA
A13   PA_00   pad_gpio_3p3_3v   NA   NA   NA
A14   SMC0_A01   pad_gpio_3p3_3v   NA   NA   NA
A15   SMC0_D00   pad_gpio_3p3_3v   NA   NA   NA
A16   SMC0_AMS0b   pad_gpio_3p3_3v   NA   NA   NA
A17   SMC0_D03   pad_gpio_3p3_3v   NA   NA   NA
A18   SMC0_D04   pad_gpio_3p3_3v   NA   NA   NA
A19   SMC0_D07   pad_gpio_3p3_3v   NA   NA   NA
A20   SMC0_D10   pad_gpio_3p3_3v   NA   NA   NA
A21   SMC0_AWEb   pad_gpio_3p3_3v   NA   NA   NA
A22   GND   gnd   NA   NA   NA
AA01   PD_11   pad_gpio_3p3_3v   NA   NA   NA
AA02   GND   gnd   NA   NA   NA
AA03   PD_13   pad_gpio_3p3_3v   NA   NA   NA
AA04   PE_00   pad_gpio_3p3_3v   NA   NA   NA
AA05   PE_03   pad_gpio_3p3_3v   NA   NA   NA
AA06   PF_14   pad_gpio_3p3_3v   NA   NA   NA
AA07   PF_12   pad_gpio_3p3_3v   NA   NA   NA
AA08   PF_10   pad_gpio_3p3_3v   NA   NA   NA
AA09   PF_08   pad_gpio_3p3_3v   NA   NA   NA
AA10   PF_06   pad_gpio_3p3_3v   NA   NA   NA
AA11   PF_04   pad_gpio_3p3_3v   NA   NA   NA
AA12   PF_02   pad_gpio_3p3_3v   NA   NA   NA
AA13   PF_00   pad_gpio_3p3_3v   NA   NA   NA
AA14   PG_00   pad_gpio_3p3_3v   NA   NA   NA
AA15   PE_15   pad_gpio_3p3_3v   NA   NA   NA
AA16   PE_14   pad_gpio_3p3_3v   NA   NA   NA
AA17   PG_05   pad_gpio_3p3_3v   NA   NA   NA
AA18   PG_08   pad_gpio_3p3_3v   NA   NA   NA
AA19   PG_07   pad_gpio_3p3_3v   NA   NA   NA
AA20   PG_13   pad_gpio_3p3_3v   NA   NA   NA
AA21   GND   gnd   NA   NA   NA
AA22   GND   gnd   NA   NA   NA
AB01   GND   gnd   NA   NA   NA
AB02   PD_05   pad_gpio_3p3_3v   NA   NA   NA
AB03   PD_14   pad_gpio_3p3_3v   NA   NA   NA
AB04   PE_01   pad_gpio_3p3_3v   NA   NA   NA
AB05   PE_04   pad_gpio_3p3_3v   NA   NA   NA
AB06   PF_15   pad_gpio_3p3_3v   NA   NA   NA
AB07   PF_13   pad_gpio_3p3_3v   NA   NA   NA
AB08   PF_11   pad_gpio_3p3_3v   NA   NA   NA
AB09   PF_09   pad_gpio_3p3_3v   NA   NA   NA
AB10   PF_07   pad_gpio_3p3_3v   NA   NA   NA
AB11   PF_05   pad_gpio_3p3_3v   NA   NA   NA
AB12   PF_03   pad_gpio_3p3_3v   NA   NA   NA
AB13   PF_01   pad_gpio_3p3_3v   NA   NA   NA
AB14   PE_13   pad_gpio_3p3_3v   NA   NA   NA
AB15   PG_03   pad_gpio_3p3_3v   NA   NA   NA
AB16   PG_06   pad_gpio_3p3_3v   NA   NA   NA
AB17   PG_02   pad_gpio_3p3_3v   NA   NA   NA
AB18   PG_12   pad_gpio_3p3_3v   NA   NA   NA
AB19   PG_14   pad_gpio_3p3_3v   NA   NA   NA
AB20   PG_15   pad_gpio_3p3_3v   NA   NA   NA
AB21   PG_10   pad_gpio_3p3_3v   NA   NA   NA
AB22   GND   gnd   NA   NA   NA
B01   USB0_VBUS   NC   NA   NA   NA
B02   GND   gnd   NA   NA   NA
B03   USB0_ID   NC   NA   NA   NA
B04   PB_11   pad_gpio_3p3_3v   NA   NA   NA
B05   PB_08   pad_gpio_3p3_3v   NA   NA   NA
B06   PA_15   pad_gpio_3p3_3v   NA   NA   NA
B07   PA_13   pad_gpio_3p3_3v   NA   NA   NA
B08   PA_11   pad_gpio_3p3_3v   NA   NA   NA
B09   PA_09   pad_gpio_3p3_3v   NA   NA   NA
B10   PA_07   pad_gpio_3p3_3v   NA   NA   NA
B11   PA_05   pad_gpio_3p3_3v   NA   NA   NA
B12   PA_03   pad_gpio_3p3_3v   NA   NA   NA
B13   PA_01   pad_gpio_3p3_3v   NA   NA   NA
B14   SMC0_A02   pad_gpio_3p3_3v   NA   NA   NA
B15   SMC0_D01   pad_gpio_3p3_3v   NA   NA   NA
B16   SMC0_D15   pad_gpio_3p3_3v   NA   NA   NA
B17   SMC0_D09   pad_gpio_3p3_3v   NA   NA   NA
B18   SMC0_D02   pad_gpio_3p3_3v   NA   NA   NA
B19   SMC0_D13   pad_gpio_3p3_3v   NA   NA   NA
B20   SMC0_D05   pad_gpio_3p3_3v   NA   NA   NA
B21   GND   gnd   NA   NA   NA
B22   SMC0_AOEb_NORDV   pad_gpio_3p3_3v   NA   NA   NA
C01   USB0_CLKIN   NC   NA   NA   NA
C02   USB0_VBC   NC   NA   NA   NA
C03   GND   gnd   NA   NA   NA
C04   PB_12   pad_gpio_3p3_3v   NA   NA   NA
C05   PB_09   pad_gpio_3p3_3v   NA   NA   NA
C06   PB_06   pad_gpio_3p3_3v   NA   NA   NA
C07   PB_05   pad_gpio_3p3_3v   NA   NA   NA
C08   PB_04   pad_gpio_3p3_3v   NA   NA   NA
C09   PB_03   pad_gpio_3p3_3v   NA   NA   NA
C10   PB_02   pad_gpio_3p3_3v   NA   NA   NA
C11   PB_01   pad_gpio_3p3_3v   NA   NA   NA
C12   PB_00   pad_gpio_3p3_3v   NA   NA   NA
C13   SMC0_BRb   pad_gpio_3p3_3v   NA   NA   NA
C14   SMC0_D06   pad_gpio_3p3_3v   NA   NA   NA
C15   SMC0_D12   pad_gpio_3p3_3v   NA   NA   NA
C16   SMC0_AREb   pad_gpio_3p3_3v   NA   NA   NA
C17   SMC0_D08   pad_gpio_3p3_3v   NA   NA   NA
C18   SMC0_D11   pad_gpio_3p3_3v   NA   NA   NA
C19   SMC0_D14   pad_gpio_3p3_3v   NA   NA   NA
C20   GND   gnd   NA   NA   NA
C21   TWI1_SCL   PIIC400K   NA   NA   NA
C22   TWI0_SCL   PIIC400K   NA   NA   NA
D01   JTG_TDI   pad_gpio_3p3_3v   NA   NA   NA
D02   JTG_TDO   pad_gpio_3p3_3v   NA   NA   NA
D03   JTG_TCK   pad_gpio_3p3_3v   NA   NA   NA
D11   VDD_EXT   POWER   NA   NA   NA
D12   GND   gnd   NA   NA   NA
D20   SMC0_ARDY_NORWT   pad_gpio_3p3_3v   NA   NA   NA
D21   TWI1_SDA   PIIC400K   NA   NA   NA
D22   TWI0_SDA   PIIC400K   NA   NA   NA
E01   JTG_TRSTb   pad_gpio_3p3_3v   NA   NA   NA
E02   JTG_EMUb   pad_gpio_3p3_3v   NA   NA   NA
E03   JTG_TMS   pad_gpio_3p3_3v   NA   NA   NA
E05   VDD_USB   POWER   NA   NA   NA
E20   DMC0_CASb   PMEMIO   NA   NA   NA
E21   DMC0_DQ10   PMEMIO   NA   NA   NA
E22   DMC0_DQ13   PMEMIO   NA   NA   NA
F01   SYS_FAULTb   pad_gpio_3p3_3v   NA   NA   NA
F02   SYS_FAULT   pad_gpio_3p3_3v   NA   NA   NA
F03   SYS_NMI_RESOUTb   pad_gpio_3p3_3v   NA   NA   NA
F06   VDD_EXT   POWER   NA   NA   NA
F07   VDD_INT   POWER   NA   NA   NA
F08   VDD_INT   POWER   NA   NA   NA
F09   VDD_INT   POWER   NA   NA   NA
F10   VDD_INT   POWER   NA   NA   NA
F11   VDD_EXT   POWER   NA   NA   NA
F12   VDD_EXT   POWER   NA   NA   NA
F13   VDD_INT   POWER   NA   NA   NA
F14   VDD_INT   POWER   NA   NA   NA
F15   VDD_INT   POWER   NA   NA   NA
F16   VDD_INT   POWER   NA   NA   NA
F17   VDD_DMC   POWER   NA   NA   NA
F20   DMC0_CS0b   PMEMIO   NA   NA   NA
F21   DMC0_DQ15   PMEMIO   NA   NA   NA
F22   DMC0_DQ08   PMEMIO   NA   NA   NA
G01   GND   gnd   NA   NA   NA
G02   SYS_HWRSTb   pad_gpio_3p3_3v   NA   NA   NA
G03   SYS_BMODE2   pad_gpio_3p3_3v   NA   NA   NA
G06   VDD_EXT   POWER   NA   NA   NA
G07   VDD_EXT   POWER   NA   NA   NA
G08   VDD_INT   POWER   NA   NA   NA
G09   VDD_INT   POWER   NA   NA   NA
G10   VDD_EXT   POWER   NA   NA   NA
G11   VDD_EXT   POWER   NA   NA   NA
G12   VDD_EXT   POWER   NA   NA   NA
G13   VDD_EXT   POWER   NA   NA   NA
G14   VDD_INT   POWER   NA   NA   NA
G15   VDD_INT   POWER   NA   NA   NA
G16   VDD_DMC   POWER   NA   NA   NA
G17   VDD_DMC   POWER   NA   NA   NA
G20   DMC0_UDM   PMEMIO   NA   NA   NA
G21   DMC0_UDQS   PMEMIODIF   NA   NA   NA
G22   DMC0_UDQSb   PMEMIODIF   NA   NA   NA
H01   SYS_CLKIN   NC   NA   NA   NA
H02   SYS_XTAL   NC   NA   NA   NA
H03   SYS_BMODE1   pad_gpio_3p3_3v   NA   NA   NA
H06   VDD_EXT   POWER   NA   NA   NA
H07   VDD_EXT   POWER   NA   NA   NA
H16   VDD_DMC   POWER   NA   NA   NA
H17   VDD_DMC   POWER   NA   NA   NA
H20   DMC0_RASb   PMEMIO   NA   NA   NA
H21   DMC0_DQ09   PMEMIO   NA   NA   NA
H22   DMC0_DQ14   PMEMIO   NA   NA   NA
J01   GND   gnd   NA   NA   NA
J02   SYS_PWRGD   pad_gpio_3p3_3v   NA   NA   NA
J03   SYS_BMODE0   pad_gpio_3p3_3v   NA   NA   NA
J06   VDD_EXT   POWER   NA   NA   NA
J09   GND   gnd   NA   NA   NA
J10   GND   gnd   NA   NA   NA
J11   GND   gnd   NA   NA   NA
J12   GND   gnd   NA   NA   NA
J13   GND   gnd   NA   NA   NA
J14   GND   gnd   NA   NA   NA
J17   VDD_DMC   POWER   NA   NA   NA
J20   DMC0_ODT   PMEMIO   NA   NA   NA
J21   DMC0_DQ12   PMEMIO   NA   NA   NA
J22   DMC0_DQ11   PMEMIO   NA   NA   NA
K01   PC_00   pad_gpio_3p3_3v   NA   NA   NA
K02   SYS_EXTWAKE   pad_gpio_3p3_3v   NA   NA   NA
K03   PB_13   pad_gpio_3p3_3v   NA   NA   NA
K06   VDD_EXT   POWER   NA   NA   NA
K08   GND   gnd   NA   NA   NA
K09   GND   gnd   NA   NA   NA
K10   GND   gnd   NA   NA   NA
K11   GND   gnd   NA   NA   NA
K12   GND   gnd   NA   NA   NA
K13   GND   gnd   NA   NA   NA
K14   GND   gnd   NA   NA   NA
K15   GND   gnd   NA   NA   NA
K17   VDD_DMC   POWER   NA   NA   NA
K20   DMC0_LDM   PMEMIO   NA   NA   NA
K21   DMC0_LDQSb   PMEMIODIF   NA   NA   NA
K22   DMC0_LDQS   PMEMIODIF   NA   NA   NA
L01   PC_02   pad_gpio_3p3_3v   NA   NA   NA
L02   PC_01   pad_gpio_3p3_3v   NA   NA   NA
L03   PB_14   pad_gpio_3p3_3v   NA   NA   NA
L04   VDD_EXT   POWER   NA   NA   NA
L06   VDD_EXT   POWER   NA   NA   NA
L08   GND   gnd   NA   NA   NA
L09   GND   gnd   NA   NA   NA
L10   GND   gnd   NA   NA   NA
L11   GND   gnd   NA   NA   NA
L12   GND   gnd   NA   NA   NA
L13   GND   gnd   NA   NA   NA
L14   GND   gnd   NA   NA   NA
L15   GND   gnd   NA   NA   NA
L17   VDD_DMC   POWER   NA   NA   NA
L19   VREF_DMC   POWER   NA   NA   NA
L20   DMC0_CKb   PMEMIODIF   NA   NA   NA
L21   DMC0_DQ06   PMEMIO   NA   NA   NA
L22   DMC0_DQ07   PMEMIO   NA   NA   NA
M01   PC_04   pad_gpio_3p3_3v   NA   NA   NA
M02   PC_03   pad_gpio_3p3_3v   NA   NA   NA
M03   PB_15   pad_gpio_3p3_3v   NA   NA   NA
M04   GND   gnd   NA   NA   NA
M06   VDD_EXT   POWER   NA   NA   NA
M08   GND   gnd   NA   NA   NA
M09   GND   gnd   NA   NA   NA
M10   GND   gnd   NA   NA   NA
M11   GND   gnd   NA   NA   NA
M12   GND   gnd   NA   NA   NA
M13   GND   gnd   NA   NA   NA
M14   GND   gnd   NA   NA   NA
M15   GND   gnd   NA   NA   NA
M17   VDD_DMC   POWER   NA   NA   NA
M19   GND   gnd   NA   NA   NA
M20   DMC0_CK   PMEMIODIF   NA   NA   NA
M21   DMC0_DQ00   PMEMIO   NA   NA   NA
M22   DMC0_DQ01   PMEMIO   NA   NA   NA
N01   PC_06   pad_gpio_3p3_3v   NA   NA   NA
N02   PC_05   pad_gpio_3p3_3v   NA   NA   NA
N03   SYS_CLKOUT   pad_gpio_3p3_3v   NA   NA   NA
N06   VDD_EXT   POWER   NA   NA   NA
N08   GND   gnd   NA   NA   NA
N09   GND   gnd   NA   NA   NA
N10   GND   gnd   NA   NA   NA
N11   GND   gnd   NA   NA   NA
N12   GND   gnd   NA   NA   NA
N13   GND   gnd   NA   NA   NA
N14   GND   gnd   NA   NA   NA
N15   GND   gnd   NA   NA   NA
N17   VDD_DMC   POWER   NA   NA   NA
N20   DMC0_Web   PMEMIO   NA   NA   NA
N21   DMC0_DQ04   PMEMIO   NA   NA   NA
N22   DMC0_DQ03   PMEMIO   NA   NA   NA
P01   PC_08   pad_gpio_3p3_3v   NA   NA   NA
P02   PC_07   pad_gpio_3p3_3v   NA   NA   NA
P03   PD_06   pad_gpio_3p3_3v   NA   NA   NA
P06   VDD_EXT   POWER   NA   NA   NA
P09   GND   gnd   NA   NA   NA
P10   GND   gnd   NA   NA   NA
P11   GND   gnd   NA   NA   NA
P12   GND   gnd   NA   NA   NA
P13   GND   gnd   NA   NA   NA
P14   GND   gnd   NA   NA   NA
P17   VDD_DMC   POWER   NA   NA   NA
P20   DMC0_CKE   PMEMIO   NA   NA   NA
P21   DMC0_DQ02   PMEMIO   NA   NA   NA
P22   DMC0_DQ05   PMEMIO   NA   NA   NA
R01   PC_10   pad_gpio_3p3_3v   NA   NA   NA
R02   PC_09   pad_gpio_3p3_3v   NA   NA   NA
R03   PD_07   pad_gpio_3p3_3v   NA   NA   NA
R06   VDD_EXT   POWER   NA   NA   NA
R07   VDD_EXT   POWER   NA   NA   NA
R16   VDD_DMC   POWER   NA   NA   NA
R17   VDD_DMC   POWER   NA   NA   NA
R20   DMC0_BA2   PMEMIO   NA   NA   NA
R21   DMC0_BA0   PMEMIO   NA   NA   NA
R22   DMC0_A10   PMEMIO   NA   NA   NA
T01   PC_12   pad_gpio_3p3_3v   NA   NA   NA
T02   PC_11   pad_gpio_3p3_3v   NA   NA   NA
T03   PD_08   pad_gpio_3p3_3v   NA   NA   NA
T06   VDD_EXT   POWER   NA   NA   NA
T07   VDD_EXT   POWER   NA   NA   NA
T08   VDD_INT   POWER   NA   NA   NA
T09   VDD_INT   POWER   NA   NA   NA
T10   VDD_EXT   POWER   NA   NA   NA
T11   VDD_EXT   POWER   NA   NA   NA
T12   VDD_EXT   POWER   NA   NA   NA
T13   VDD_EXT   POWER   NA   NA   NA
T14   VDD_INT   POWER   NA   NA   NA
T15   VDD_INT   POWER   NA   NA   NA
T16   VDD_DMC   POWER   NA   NA   NA
T17   VDD_DMC   POWER   NA   NA   NA
T20   DMC0_A03   PMEMIO   NA   NA   NA
T21   DMC0_A07   PMEMIO   NA   NA   NA
T22   DMC0_A12   PMEMIO   NA   NA   NA
U01   PC_14   pad_gpio_3p3_3v   NA   NA   NA
U02   PC_13   pad_gpio_3p3_3v   NA   NA   NA
U03   PD_09   pad_gpio_3p3_3v   NA   NA   NA
U06   VDD_EXT   POWER   NA   NA   NA
U07   VDD_INT   POWER   NA   NA   NA
U08   VDD_INT   POWER   NA   NA   NA
U09   VDD_INT   POWER   NA   NA   NA
U10   VDD_INT   POWER   NA   NA   NA
U11   VDD_EXT   POWER   NA   NA   NA
U12   VDD_EXT   POWER   NA   NA   NA
U13   VDD_INT   POWER   NA   NA   NA
U14   VDD_INT   POWER   NA   NA   NA
U15   VDD_INT   POWER   NA   NA   NA
U16   VDD_INT   POWER   NA   NA   NA
U17   VDD_DMC   POWER   NA   NA   NA
U20   DMC0_A09   PMEMIO   NA   NA   NA
U21   DMC0_A05   PMEMIO   NA   NA   NA
U22   DMC0_A01   PMEMIO   NA   NA   NA
V01   PD_00   pad_gpio_3p3_3v   NA   NA   NA
V02   PC_15   pad_gpio_3p3_3v   NA   NA   NA
V03   PD_10   pad_gpio_3p3_3v   NA   NA   NA
V20   DMC0_BA1   PMEMIO   NA   NA   NA
V21   DMC0_A13   PMEMIO   NA   NA   NA
V22   DMC0_A11   PMEMIO   NA   NA   NA
W01   PD_04   pad_gpio_3p3_3v   NA   NA   NA
W02   PD_01   pad_gpio_3p3_3v   NA   NA   NA
W03   PD_12   pad_gpio_3p3_3v   NA   NA   NA
W11   GND   gnd   NA   NA   NA
W12   VDD_TD   POWER   NA   NA   NA
W20   DMC0_A04   PMEMIO   NA   NA   NA
W21   DMC0_A06   PMEMIO   NA   NA   NA
W22   DMC0_A08   PMEMIO   NA   NA   NA
Y01   PD_03   pad_gpio_3p3_3v   NA   NA   NA
Y02   PD_02   pad_gpio_3p3_3v   NA   NA   NA
Y03   GND   gnd   NA   NA   NA
Y04   PD_15   pad_gpio_3p3_3v   NA   NA   NA
Y05   PE_02   pad_gpio_3p3_3v   NA   NA   NA
Y06   PE_05   pad_gpio_3p3_3v   NA   NA   NA
Y07   PE_06   pad_gpio_3p3_3v   NA   NA   NA
Y08   PE_07   pad_gpio_3p3_3v   NA   NA   NA
Y09   PE_08   pad_gpio_3p3_3v   NA   NA   NA
Y10   PE_09   pad_gpio_3p3_3v   NA   NA   NA
Y11   SYS_TDK   NC   NA   NA   NA
Y12   SYS_TDA   NC   NA   NA   NA
Y13   PE_12   pad_gpio_3p3_3v   NA   NA   NA
Y14   PE_10   pad_gpio_3p3_3v   NA   NA   NA
Y15   PE_11   pad_gpio_3p3_3v   NA   NA   NA
Y16   PG_09   pad_gpio_3p3_3v   NA   NA   NA
Y17   PG_01   pad_gpio_3p3_3v   NA   NA   NA
Y18   PG_04   pad_gpio_3p3_3v   NA   NA   NA
Y19   PG_11   pad_gpio_3p3_3v   NA   NA   NA
Y20   GND   gnd   NA   NA   NA
Y21   DMC0_A00   PMEMIO   NA   NA   NA
Y22   DMC0_A02   PMEMIO   NA   NA   NA
[Diff Pin] inv_pin   vdiff   tdelay_typ tdelay_min tdelay_max
G21   G22   0.9V   NA   NA   NA
K22   K21   0.9V   NA   NA   NA
M20   L20   0.9V   NA   NA   NA
[Model Selector] pad_gpio_3p3_3v
gpio_3p3 3.3V
gpio_1p8 1.8V
[Model Selector] PMEMIO
pmemio_full full drive
pmemio_half half drive
[Model Selector] PMEMIODIF
pmemiodif_full full drive
pmemiodif_half half drive
[Model Selector] PIIC400K
PIIC400K_S1 S1
PIIC400K_S2 S2
PIIC400K_S5 S5
PIIC400K_S6 S6
PIIC400K_S7 S7
| Models and submodels in the file (15): pmemio_full (I/O), pmemio_half (I/O), pmemiodif_full (I/O), pmemiodif_half (I/O), pmemiopl_full (I/O), pmemiopl_half (I/O), gpio_1p8 (I/O), gpio_3p3 (I/O), PIIC400K_S1 (I/O_open_drain), PIIC400K_S2 (I/O_open_drain), PIIC400K_S3 (I/O_open_drain), PIIC400K_S4 (I/O_open_drain), PIIC400K_S5 (I/O_open_drain), PIIC400K_S6 (I/O_open_drain), PIIC400K_S7 (I/O_open_drain)
