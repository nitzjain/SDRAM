| y14w.ibs * IBIS 4.0 Model
| 64Meg SDRAM - Die Revision "G"
| This Model is valid for Commercial Temperature Range 0C<=Tc<=70C
| Part Number   VDD/VDDQ   Architecture   Package
| MT48LC16M4A2TG   3.3V/3.3V   16 Meg x 4   54-pin TSOP
| MT48LC8M8A2TG   3.3V/3.3V   8 Meg x 8   54-pin TSOP
| MT48LC4M16A2TG   3.3V/3.3V   4 Meg x 16   54-pin TSOP
| MT48LC4M16A2F4   3.3V/3.3V   4 Meg x 16   54-ball VFBGA
[IBIS Ver]   4.0
[File name]   y14w.ibs
[File rev]   2.2
[Date]   06/18/2008
[Source]   From silicon level SPICE model at Micron Technology, Inc.
   For support e-mail modelsupport@micron.com
[Notes]   Rev 1.0: 01/22/2004
   - initial file creation
   Rev 2.0: 04/02/2004
   - updated all models to match latest silicon measurements
   - updated C_comp values for all models
   - added TSOP package parasitics
   Rev 2.1: 08/10/2007
   - added 54-ball VFBGA package
   Rev 2.2: 06/18/2008
   - updated all package parasitics
   - updated C_comp in all models to match latest measurements
   - updated all models to match latest silicon measurements
   - changed IBIS version to 4.0
   - IQ SUMMARY: Overall Quality of component and models Level
   2b. See Micron IBIS Model Quality Report for full IQ SUMMARY
[Disclaimer]  This software code and all associated documentation, comments
              or other information (collectively "Software") is provided
              "AS IS" without warranty of any kind. MICRON TECHNOLOGY, INC.
              ("MTI") EXPRESSLY DISCLAIMS ALL WARRANTIES EXPRESS OR IMPLIED,
              INCLUDING BUT NOT LIMITED TO, NONINFRINGEMENT OF THIRD PARTY
              RIGHTS, AND ANY IMPLIED WARRANTIES OF MERCHANTABILITY OR
              FITNESS FOR ANY PARTICULAR PURPOSE. MTI DOES NOT WARRANT THAT
              THE SOFTWARE WILL MEET YOUR REQUIREMENTS, OR THAT THE
              OPERATION OF THE SOFTWARE WILL BE UNINTERRUPTED OR ERROR-FREE.
              FURTHERMORE, MTI DOES NOT MAKE ANY REPRESENTATIONS REGARDING
              THE USE OR THE RESULTS OF THE USE OF THE SOFTWARE IN TERMS OF
              ITS CORRECTNESS, ACCURACY, RELIABILITY, OR OTHERWISE. THE
              ENTIRE RISK ARISING OUT OF USE OR PERFORMANCE OF THE SOFTWARE
              REMAINS WITH YOU. IN NO EVENT SHALL MTI, ITS AFFILIATED
              COMPANIES OR THEIR SUPPLIERS BE LIABLE FOR ANY DIRECT,
              INDIRECT, CONSEQUENTIAL, INCIDENTAL, OR SPECIAL DAMAGES
              (INCLUDING, WITHOUT LIMITATION, DAMAGES FOR LOSS OF PROFITS,
              BUSINESS INTERRUPTION, OR LOSS OF INFORMATION) ARISING OUT OF
              YOUR USE OF OR INABILITY TO USE THE SOFTWARE, EVEN IF MTI HAS
              BEEN ADVISED OF THE POSSIBILITY OF SUCH DAMAGES. Because some
              jurisdictions prohibit the exclusion or limitation of
              liability for consequential or incidental damages, the above
              limitation may not apply to you.
[Copyright]   Copyright 2004 Micron Technology, Inc. All Rights Reserved.
|   COMPONENT: MT48LC16M4A2TG
[Component]   MT48LC16M4A2TG
[Manufacturer]   Micron Technology, Inc.
[Package]   | 54-pin TSOP
| variable   typ   min   max
R_pkg   107.6m   72.1m   122.5m
L_pkg   6.336nH   4.149nH   8.007nH
C_pkg   1.005pF   0.559pF   1.331pF
[Pin]  signal_name  model_name   R_pin   L_pin   C_pin
1   VDD   POWER   83.9m   7.688nH   1.030pF
2   NC   NC
3   VDDQ   POWER   81.3m   6.271nH   1.027pF
4   NC   NC
5   DQ0   dqbuff   72.1m   4.968nH   0.791pF
6   VSSQ   GND   67.8m   4.391nH   0.936pF
7   NC   NC
8   NC   NC
9   VDDQ   POWER   58.5m   3.163nH   0.488pF
10   NC   NC
11   DQ1   dqbuff   86.7m   4.215nH   0.559pF
12   VSSQ   GND   86.9m   4.102nH   0.936pF
13   NC   NC
14   VDD   POWER   91.7m   4.442nH   0.674pF
15   NC   NC
16   WE#   webuff   98.9m   4.923nH   0.768pF
17   CAS#   inbuff   103.5m   5.277nH   0.816pF
18   RAS#   inbuff   106.0m   5.571nH   0.892pF
19   CS#   inbuff   109.8m   5.967nH   0.953pF
20   BA0   inbuff   113.2m   6.361nH   1.007pF
21   BA1   inbuff   115.1m   6.618nH   1.062pF
22   A10   inbuff   116.9m   6.964nH   1.126pF
23   A0   inbuff   119.6m   7.301nH   1.186pF
24   A1   inbuff   121.5m   7.688nH   1.237pF
25   A2   inbuff   122.5m   7.986nH   1.273pF
26   A3   inbuff   110.0m   7.906nH   1.331pF
27   VDD   POWER   102.7m   7.496nH   1.004pF
28   VSS   GND   102.7m   7.496nH   NA
29   A4   inbuff   110.6m   8.007nH   1.249pF
30   A5   inbuff   122.0m   7.949nH   1.286pF
31   A6   inbuff   120.8m   7.637nH   1.237pF
32   A7   inbuff   118.7m   7.302nH   1.200pF
33   A8   inbuff   118.1m   7.075nH   1.135pF
34   A9   inbuff   116.4m   6.793nH   1.086pF
35   A11   inbuff   115.1m   6.537nH   1.030pF
36   NC   NC
37   CKE   inbuff   108.1m   5.726nH   0.909pF
38   CLK   clkbuff   105.5m   5.411nH   0.842pF
39   DQM   dmbuff   100.5m   5.055nH   0.786pF
40   NC   NC
41   VSS   GND   91.7m   4.442nH   NA
42   NC   NC
43   VDDQ   POWER   86.9m   4.102nH   0.584pF
44   DQ2   dqbuff   86.0m   4.149nH   0.566pF
45   NC   NC
46   VSSQ   GND   58.5m   3.163nH   0.936pF
47   NC   NC
48   NC   NC
49   VDDQ   POWER   67.8m   4.391nH   0.702pF
50   DQ3   dqbuff   72.7m   5.023nH   0.793pF
51   NC   NC
52   VSSQ   GND   81.3m   6.271nH   0.936pF
53   NC   NC
54   VSS   GND   83.9m   7.688nH   NA
|   COMPONENT: MT48LC8M8A2TG
[Component]   MT48LC8M8A2TG
[Manufacturer]   Micron Technology, Inc.
[Package]   | 54-pin TSOP
| variable   typ   min   max
R_pkg   102.8m   60.5m   122.5m
L_pkg   6.180nH   3.410nH   8.007nH
C_pkg   0.979pF   0.521pF   1.331pF
[Pin]  signal_name  model_name   R_pin   L_pin   C_pin
1   VDD   POWER   83.9m   7.688nH   1.030pF
2   DQ0   dqbuff   84.8m   7.003nH   1.120pF
3   VDDQ   POWER   81.3m   6.271nH   1.027pF
4   NC   NC
5   DQ1   dqbuff   72.1m   4.968nH   0.791pF
6   VSSQ   GND   67.8m   4.391nH   0.936pF
7   NC   NC
8   DQ2   dqbuff   61.2m   3.482nH   0.523pF
9   VDDQ   POWER   58.5m   3.163nH   0.488pF
10   NC   NC
11   DQ3   dqbuff   86.7m   4.215nH   0.559pF
12   VSSQ   GND   86.9m   4.102nH   0.936pF
13   NC   NC
14   VDD   POWER   91.7m   4.442nH   0.674pF
15   NC   NC
16   WE#   webuff   98.9m   4.923nH   0.768pF
17   CAS#   inbuff   103.5m   5.277nH   0.816pF
18   RAS#   inbuff   106.0m   5.571nH   0.892pF
19   CS#   inbuff   109.8m   5.967nH   0.953pF
20   BA0   inbuff   113.2m   6.361nH   1.007pF
21   BA1   inbuff   115.1m   6.618nH   1.062pF
22   A10   inbuff   116.9m   6.964nH   1.126pF
23   A0   inbuff   119.6m   7.301nH   1.186pF
24   A1   inbuff   121.5m   7.688nH   1.237pF
25   A2   inbuff   122.5m   7.986nH   1.273pF
26   A3   inbuff   110.0m   7.906nH   1.331pF
27   VDD   POWER   102.7m   7.496nH   1.004pF
28   VSS   GND   102.7m   7.496nH   NA
29   A4   inbuff   110.6m   8.007nH   1.249pF
30   A5   inbuff   122.0m   7.949nH   1.286pF
31   A6   inbuff   120.8m   7.637nH   1.237pF
32   A7   inbuff   118.7m   7.302nH   1.200pF
33   A8   inbuff   118.1m   7.075nH   1.135pF
34   A9   inbuff   116.4m   6.793nH   1.086pF
35   A11   inbuff   115.1m   6.537nH   1.030pF
36   NC   NC
37   CKE   inbuff   108.1m   5.726nH   0.909pF
38   CLK   clkbuff   105.5m   5.411nH   0.842pF
39   DQM   dmbuff   100.5m   5.055nH   0.786pF
40   NC   NC
41   VSS   GND   91.7m   4.442nH   NA
42   NC   NC
43   VDDQ   POWER   86.9m   4.102nH   0.584pF
44   DQ4   dqbuff   86.0m   4.149nH   0.566pF
45   NC   NC
46   VSSQ   GND   58.5m   3.163nH   0.936pF
47   DQ5   dqbuff   60.5m   3.410nH   0.521pF
48   NC   NC
49   VDDQ   POWER   67.8m   4.391nH   0.702pF
50   DQ6   dqbuff   72.7m   5.023nH   0.793pF
51   NC   NC
52   VSSQ   GND   81.3m   6.271nH   0.936pF
53   DQ7   dqbuff   84.4m   6.911nH   1.111pF
54   VSS   GND   83.9m   7.688nH   NA
|   COMPONENT: MT48LC4M16A2TG
[Component]   MT48LC4M16A2TG
[Manufacturer]   Micron Technology, Inc.
[Package]   | 54-pin TSOP
| variable   typ   min   max
R_pkg   97.5m   60.5m   122.5m
L_pkg   5.787nH   3.410nH   8.007nH
C_pkg   0.907pF   0.517pF   1.331pF
[Pin]  signal_name  model_name   R_pin   L_pin   C_pin
1   VDD   POWER   83.9m   7.688nH   1.030pF
2   DQ0   dqbuff   84.8m   7.003nH   1.120pF
3   VDDQ   POWER   81.3m   6.271nH   1.027pF
4   DQ1   dqbuff   77.0m   5.632nH   0.902pF
5   DQ2   dqbuff   72.1m   4.968nH   0.791pF
6   VSSQ   GND   67.8m   4.391nH   0.936pF
7   DQ3   dqbuff   64.4m   3.988nH   0.613pF
8   DQ4   dqbuff   61.2m   3.482nH   0.523pF
9   VDDQ   POWER   58.5m   3.163nH   0.488pF
10   DQ5   dqbuff   83.3m   4.184nH   0.517pF
11   DQ6   dqbuff   86.7m   4.215nH   0.559pF
12   VSSQ   GND   86.9m   4.102nH   0.936pF
13   DQ7   dqbuff   89.4m   4.256nH   0.640pF
14   VDD   POWER   91.7m   4.442nH   0.674pF
15   DQML   dmbuff   95.8m   4.728nH   0.727pF
16   WE#   webuff   98.9m   4.923nH   0.768pF
17   CAS#   inbuff   103.5m   5.277nH   0.816pF
18   RAS#   inbuff   106.0m   5.571nH   0.892pF
19   CS#   inbuff   109.8m   5.967nH   0.953pF
20   BA0   inbuff   113.2m   6.361nH   1.007pF
21   BA1   inbuff   115.1m   6.618nH   1.062pF
22   A10   inbuff   116.9m   6.964nH   1.126pF
23   A0   inbuff   119.6m   7.301nH   1.186pF
24   A1   inbuff   121.5m   7.688nH   1.237pF
25   A2   inbuff   122.5m   7.986nH   1.273pF
26   A3   inbuff   110.0m   7.906nH   1.331pF
27   VDD   POWER   102.7m   7.496nH   1.004pF
28   VSS   GND   102.7m   7.496nH   NA
29   A4   inbuff   110.6m   8.007nH   1.249pF
30   A5   inbuff   122.0m   7.949nH   1.286pF
31   A6   inbuff   120.8m   7.637nH   1.237pF
32   A7   inbuff   118.7m   7.302nH   1.200pF
33   A8   inbuff   118.1m   7.075nH   1.135pF
34   A9   inbuff   116.4m   6.793nH   1.086pF
35   A11   inbuff   115.1m   6.537nH   1.030pF
36   NC   NC
37   CKE   inbuff   108.1m   5.726nH   0.909pF
38   CLK   clkbuff   105.5m   5.411nH   0.842pF
39   DQMH   dmbuff   100.5m   5.055nH   0.786pF
40   NC   NC
41   VSS   GND   91.7m   4.442nH   NA
42   DQ8   dqbuff   88.4m   4.197nH   0.623pF
43   VDDQ   POWER   86.9m   4.102nH   0.584pF
44   DQ9   dqbuff   86.0m   4.149nH   0.566pF
45   DQ10   dqbuff   85.7m   4.162nH   0.527pF
46   VSSQ   GND   58.5m   3.163nH   0.936pF
47   DQ11   dqbuff   60.5m   3.410nH   0.521pF
48   DQ12   dqbuff   63.8m   3.926nH   0.614pF
49   VDDQ   POWER   67.8m   4.391nH   0.702pF
50   DQ13   dqbuff   72.7m   5.023nH   0.793pF
51   DQ14   dqbuff   77.1m   5.621nH   0.902pF
52   VSSQ   GND   81.3m   6.271nH   0.936pF
53   DQ15   dqbuff   84.4m   6.911nH   1.111pF
54   VSS   GND   83.9m   7.688nH   NA
|   COMPONENT: MT48LC4M16A2F4
[Component]   MT48LC4M16A2F4
[Manufacturer]   Micron Technology, Inc.
[Package]   | 8mm x 8mm 54-ball VFBGA
| variable   typ   min   max
R_pkg   307.9m   139.1m   505.0m
L_pkg   3.95nH   1.82nH   7.22nH
C_pkg   1.336pF   0.667pF   2.208pF
[Pin]  signal_name  model_name   R_pin   L_pin   C_pin
A1   VSS   GND   63.1m   0.990nH   NA
A2   DQ15   dqbuff   216.4m   3.310nH   1.069pF
A3   VSSQ   GND   49.4m   0.699nH   4.998pF
A7   VDDQ   POWER   42.0m   0.567nH   5.280pF
A8   DQ0   dqbuff   219.5m   3.209nH   1.084pF
A9   VDD   POWER   59.1m   0.975nH   7.917pF
B1   DQ14   dqbuff   194.3m   2.938nH   0.844pF
B2   DQ13   dqbuff   139.1m   1.823nH   0.769pF
B3   VDDQ   POWER   42.0m   0.567nH   5.280pF
B7   VSSQ   GND   49.4m   0.699nH   4.998pF
B8   DQ2   dqbuff   225.4m   3.185nH   1.239pF
B9   DQ1   dqbuff   276.3m   3.971nH   1.395pF
C1   DQ12   dqbuff   198.1m   2.729nH   1.017pF
C2   DQ11   dqbuff   188.8m   2.574nH   0.817pF
C3   VSSQ   GND   49.4m   0.699nH   4.998pF
C7   VDDQ   POWER   42.0m   0.567nH   5.280pF
C8   DQ4   dqbuff   191.8m   2.618nH   1.079pF
C9   DQ3   dqbuff   245.8m   3.615nH   1.306pF
D1   DQ10   dqbuff   179.4m   2.882nH   0.753pF
D2   DQ9   dqbuff   331.7m   3.508nH   1.404pF
D3   VDDQ   POWER   42.0m   0.567nH   5.280pF
D7   VSSQ   GND   49.4m   0.699nH   4.998pF
D8   DQ6   dqbuff   411.6m   5.196nH   1.720pF
D9   DQ5   dqbuff   181.5m   2.947nH   0.667pF
E1   DQ8   dqbuff   356.0m   4.100nH   1.429pF
E2   NC   NC
E3   VSS   GND   63.1m   0.990nH   NA
E7   VDD   POWER   59.1m   0.975nH   7.917pF
E8   DQML   dmbuff   447.4m   5.838nH   2.065pF
E9   DQ7   dqbuff   316.1m   4.133nH   1.147pF
F1   DQMH   dmbuff   383.0m   4.589nH   1.626pF
F2   CLK   clkbuff   404.4m   5.092nH   1.773pF
F3   CKE   inbuff   340.4m   3.895nH   1.547pF
F7   CAS#   inbuff   351.5m   4.243nH   1.639pF
F8   RAS#   inbuff   421.2m   5.708nH   1.863pF
F9   WE#   webuff   505.0m   7.219nH   2.208pF
G1   NC   NC
G2   A11   inbuff   389.0m   4.856nH   1.772pF
G3   A9   inbuff   325.2m   3.762nH   1.512pF
G7   BA0   inbuff   319.9m   3.902nH   1.334pF
G8   BA1   inbuff   273.1m   3.441nH   0.882pF
G9   CS#   inbuff   302.0m   4.182nH   1.035pF
H1   A8   inbuff   318.1m   4.415nH   1.093pF
H2   A7   inbuff   362.1m   4.317nH   1.505pF
H3   A6   inbuff   298.8m   3.187nH   1.316pF
H7   A0   inbuff   300.5m   3.271nH   1.305pF
H8   A1   inbuff   404.1m   5.104nH   1.658pF
H9   A10   inbuff   275.2m   3.708nH   0.940pF
J1   VSS   GND   63.1m   0.990nH   NA
J2   A5   inbuff   392.8m   4.840nH   1.629pF
J3   A4   inbuff   322.0m   3.624nH   1.291pF
J7   A3   inbuff   312.7m   3.388nH   1.416pF
J8   A2   inbuff   381.2m   4.767nH   1.631pF
J9   VDD   POWER   59.1m   0.975nH   7.917pF
| Models and submodels in the file (5): dqbuff (I/O), clkbuff (Input), inbuff (Input), webuff (Input), dmbuff (Input)
