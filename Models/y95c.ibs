|   * y95c.ibs *  IBIS 3.2 Model for 128 Meg SDRAM
[IBIS Ver]   3.2
[File name]   y95c.ibs
[File rev]   2.2
[Date]   12/14/2001
[Source]   From silicon level SPICE model at Micron Technology, Inc.
   Micron Technology, Inc.
   8000 S. Federal Way
   P.O. Box 6, M/S: 351
   Boise, ID 83707-0006
[Notes]   Rev 2.0 initial: (02/28/2001)
   - dq model I-V curves matched to silicon measurements
   - input model of 4 different inputs
   Rev 2.1 changes: (04/24/2001)
   - added FBGA package component MT48LC16M8A2FB
   and MT48LC32M4A2FB
   Rev 2.2 changes: (12/14/01)
   - updated dq model to simulate the capacitance
   of the esd devices
   - clamp curves updated on all models
[Disclaimer] THESE DESIGNS ARE PROVIDED "AS IS" WITH NO WARRANTY
                WHATSOEVER AND MICRON SPECIFICALLY DISCLAIMS ANY
                IMPLIED WARRANTIES OF MERCHANTABILITY, FITNESS FOR
                A PARTICULAR PURPOSE, OR AGAINST INFRINGEMENT.
[Copyright]   Copyright 2001, Micron Technology, Inc., All Rights
   Reserved.
|   COMPONENT: MT48LC32M4A2 SDRAM
[Component]   MT48LC32M4A2
[Manufacturer]  Micron Technology, Inc.
[Package]   | TSOP package
|   typ   min   max
R_pkg   294.0m   240.0m   356.0m
L_pkg   6.38nH   4.27nH   8.19nH
C_pkg   1.10pF   0.87pF   1.27pF
[Pin] signal_name   model_name   R_pin   L_pin   C_pin
1   VCC   POWER   240m   8.03nH   0.87pf
2   NC   NC   NA   NA   NA
3   VCCQ   POWER   285m   7.71nH   1.11pf
4   NC   NC   NA   NA   NA
5   DQ0   dq   293m   6.69nH   1.12pf
6   VSSQ   GND   289m   6.33nH   1.15pf
7   NC   NC   NA   NA   NA
8   NC   NC   NA   NA   NA
9   VCCQ   POWER   280m   5.37nH   1.03pf
10   NC   NC   NA   NA   NA
11   DQ1   dq   241m   4.40nH   0.98pf
12   VSSQ   GND   232m   4.68nH   1.01pf
13   NC   NC   NA   NA   NA
14   VCC   POWER   248m   4.27nH   0.88pf
15   NC   NC   NA   NA   NA
16   WE#   input_we   287m   4.91nH   1.02pf
17   CAS#   input   299m   5.05nH   1.05pf
18   RAS#   input   299m   5.24nH   1.10pf
19   CS#   input2   309m   5.44nH   1.17pf
20   BA0   input   330m   5.77nH   1.21pf
21   BA1   input   337m   6.16nH   1.22pf
22   A10   input   334m   6.48nH   1.27pf
23   A0   input   356m   6.96nH   1.25pf
24   A1   input   346m   7.33nH   1.23pf
25   A2   input   323m   7.70nH   1.21pf
26   A3   input   252m   7.46nH   1.10pf
27   VCC   POWER   245m   8.03nH   0.91pf
28   VSS   GND   245m   8.03nH   0.91pf
29   A4   input   252m   7.46nH   1.10pf
30   A5   input   323m   7.70nH   1.21pf
31   A6   input   346m   7.33nH   1.23pf
32   A7   input   356m   6.96nH   1.25pf
33   A8   input   334m   6.48nH   1.27pf
34   A9   input   337m   6.16nH   1.22pf
35   A11   input   330m   5.77nH   1.21pf
36   NC   NC   NA   NA   NA
37   CKE   input2   299m   5.24nH   1.10pf
38   CLK   input_clk   299m   5.05nH   1.05pf
39   DQM   input2   287m   4.91nH   1.02pf
40   NC   NC   NA   NA   NA
41   VSS   GND   248m   4.27nH   0.88pf
42   NC   NC   NA   NA   NA
43   NC   NC   NA   NA   NA
44   DQ2   dq   241m   4.40nH   0.98pf
45   NC   NC   NA   NA   NA
46   VSSQ   GND   280m   8.19nH   1.03pf
47   NC   NC   NA   NA   NA
48   NC   NC   NA   NA   NA
49   VCCQ   POWER   289m   6.33nH   1.15pf
50   DQ3   dq   293m   6.69nH   1.12pf
51   NC   NC   NA   NA   NA
52   VSSQ   GND   285m   7.71nH   1.11pf
53   NC   NC   NA   NA   NA
54   VSS   GND   240m   8.03nH   0.87pf
|   COMPONENT: MT48LC16M8A2 SDRAM
[Component]   MT48LC16M8A2
[Manufacturer]  Micron Technology, Inc.
[Package]   | TSOP package
|   typ   min   max
R_pkg   291.0m   240.0m   356.0m
L_pkg   6.39nH   4.27nH   8.19nH
C_pkg   1.09pF   0.876pF   1.27pF
[Pin] signal_name   model_name   R_pin   L_pin   C_pin
1   VCC   POWER   240m   8.03nH   0.87pf
2   DQ0   dq   242m   7.51nH   1.04pf
3   VCCQ   POWER   285m   7.71nH   1.11pf
4   NC   NC   NA   NA   NA
5   DQ1   dq   293m   6.69nH   1.12pf
6   VSSQ   GND   289m   6.33nH   1.15pf
7   NC   NC   NA   NA   NA
8   DQ2   dq   276m   5.37nH   1.08pf
9   VCCQ   POWER   280m   5.37nH   1.03pf
10   NC   NC   NA   NA   NA
11   DQ3   dq   241m   4.40nH   0.98pf
12   VSSQ   GND   232m   4.68nH   1.01pf
13   NC   NC   NA   NA   NA
14   VCC   POWER   248m   4.27nH   0.88pf
15   NC   NC   NA   NA   NA
16   WE#   input_we   287m   4.91nH   1.02pf
17   CAS#   input   299m   5.05nH   1.05pf
18   RAS#   input   299m   5.24nH   1.10pf
19   CS#   input2   309m   5.44nH   1.17pf
20   BA0   input   330m   5.77nH   1.21pf
21   BA1   input   337m   6.16nH   1.22pf
22   A10   input   334m   6.48nH   1.27pf
23   A0   input   356m   6.96nH   1.25pf
24   A1   input   346m   7.33nH   1.23pf
25   A2   input   323m   7.70nH   1.21pf
26   A3   input   252m   7.46nH   1.10pf
27   VCC   POWER   245m   8.03nH   0.91pf
28   VSS   GND   245m   8.03nH   0.91pf
29   A4   input   252m   7.46nH   1.10pf
30   A5   input   323m   7.70nH   1.21pf
31   A6   input   346m   7.33nH   1.23pf
32   A7   input   356m   6.96nH   1.25pf
33   A8   input   334m   6.48nH   1.27pf
34   A9   input   337m   6.16nH   1.22pf
35   A11   input   330m   5.77nH   1.21pf
36   NC   NC   NA   NA   NA
37   CKE   input2   299m   5.24nH   1.10pf
38   CLK   input_clk   299m   5.05nH   1.05pf
39   DQM   input2   287m   4.91nH   1.02pf
40   NC   NC   NA   NA   NA
41   VSS   GND   248m   4.27nH   0.88pf
42   NC   NC   NA   NA   NA
43   NC   NC   NA   NA   NA
44   DQ4   dq   241m   4.40nH   0.98pf
45   NC   NC   NA   NA   NA
46   VSSQ   GND   280m   8.19nH   1.03pf
47   DQ5   dq   276m   5.37nH   1.08pf
48   NC   NC   NA   NA   NA
49   VCCQ   POWER   289m   6.33nH   1.15pf
50   DQ6   dq   293m   6.69nH   1.12pf
51   NC   NC   NA   NA   NA
52   VSSQ   GND   285m   7.71nH   1.11pf
53   DQ7   dq   242m   7.51nH   1.04pf
54   VSS   GND   240m   8.03nH   0.87pf
|   COMPONENT: MT48LC16M8A2FB SDRAM
[Component]   MT48LC16M8A2FB
[Manufacturer]  Micron Technology, Inc.
[Package]   | FBGA Package
|   typ   min   max
R_pkg   106m   89m   124m
L_pkg   3.73nH   2.93nH   4.93nH
C_pkg   0.65pF   0.45pF   0.77pF
[Pin]  signal_name   model_name   R_pin   L_pin   C_pin
1A   DQ7   dq   115m   4.40nH   0.66pF
1B   NC   NC   NA   NA   NA
1C   VDDQ   POWER   116m   4.20nH   0.66pF
1D   DQ5   dq   112m   3.98nH   0.66pF
1E   NC   NC   NA   NA   NA
1F   VDDQ   POWER   107m   3.90nH   0.61pF
1G   NC   NC   NA   NA   NA
1H   NC   NC   NA   NA   NA
1J   NC   NC   NA   NA   NA
1K   NC   NC   NA   NA   NA
1L   NC   NC   NA   NA   NA
1M   A11   input   121m   4.33nH   0.71pF
1N   A8   input   123m   4.52nH   0.73pF
1P   A6   input   123m   4.59nH   0.70pF
1Q   A4   input   124m   4.93nH   0.68pF
2A   VSS   GND   91m   3.43nH   0.53pF
2B   VSSQ   GND   101m   3.53nH   0.72pF
2C   DQ6   dq   101m   3.40nH   0.70pF
2D   NC   NC   NA   NA   NA
2E   VSSQ   GND   94m   3.21nH   0.63pF
2F   DQ4   dq   93m   3.13nH   0.62pF
2G   NC   NC   NA   NA   NA
2H   VSS   GND   89m   3.07nH   0.53pF
2J   DQM   input2   90m   2.93nH   0.55pF
2K   CLK   input_clk   94m   3.13nH   0.60pF
2L   CKE   input2   103m   3.52nH   0.69pF
2M   A9   input   107m   3.60nH   0.75pF
2N   A7   input   109m   3.73nH   0.72pF
2P   A5   input   108m   3.78nH   0.70pF
2Q   VSS   GND   105m   3.89nH   0.56pF
7A   VDD   POWER   95m   3.52nH   0.58pF
7B   VDDQ   POWER   102m   3.50nH   0.77pF
7C   DQ1   dq   100m   3.29nH   0.65pF
7D   NC   NC   NA   NA   NA
7E   VDDQ   POWER   93m   3.15nH   0.61pF
7F   DQ3   dq   92m   2.95nH   0.62pF
7G   NC   NC   NA   NA   NA
7H   VDD   POWER   91m   3.08nH   0.57pF
7J   WE#   input_we   91m   3.04nH   0.61pF
7K   RAS#   input   93m   3.08nH   0.62pF
7L   NC   NC   NA   NA   NA
7M   BA1   input   100m   3.30nH   0.67pF
7N   A0   input   104m   3.42nH   0.70pF
7P   A2   input   110m   3.63nH   0.74pF
7Q   VDD   POWER   109m   4.03nH   0.60pF
8A   DQ0   dq   118m   4.46nH   0.73pF
8B   NC   NC   NA   NA   NA
8C   VSSQ   GND   112m   4.07nH   0.64pF
8D   DQ2   dq   110m   4.01nH   0.62pF
8E   NC   NC   NA   NA   NA
8F   VSSQ   GND   107m   3.81nH   0.62pF
8G   NC   NC   NA   NA   NA
8H   NC   NC   NA   NA   NA
8J   CAS#   input   108m   3.88nH   0.60pF
8K   NC   NC   NA   NA   NA
8L   CS#   input2   111m   3.95nH   0.63pF
8M   BA0   input   113m   4.00nH   0.65pF
8N   A10   input   117m   4.52nH   0.68pF
8P   A1   input   122m   4.42nH   0.70pF
8Q   A3   input   121m   4.74nH   0.73pF
|   COMPONENT: MT48LC32M4A2FB SDRAM
[Component]   MT48LC32M4A2FB
[Manufacturer]  Micron Technology, Inc.
[Package]   | FBGA Package
|   typ   min   max
R_pkg   106m   89m   124m
L_pkg   3.73nH   2.93nH   4.93nH
C_pkg   0.65pF   0.45pF   0.77pF
[Pin]  signal_name   model_name   R_pin   L_pin   C_pin
1A   NC   NC   NA   NA   NA
1B   NC   NC   NA   NA   NA
1C   VDDQ   POWER   116m   4.20nH   0.66pF
1D   NC   NC   NA   NA   NA
1E   NC   NC   NA   NA   NA
1F   VDDQ   POWER   107m   3.90nH   0.61pF
1G   NC   NC   NA   NA   NA
1H   NC   NC   NA   NA   NA
1J   NC   NC   NA   NA   NA
1K   NC   NC   NA   NA   NA
1L   NC   NC   NA   NA   NA
1M   A11   input   121m   4.33nH   0.71pF
1N   A8   input   123m   4.52nH   0.73pF
1P   A6   input   123m   4.59nH   0.70pF
1Q   A4   input   124m   4.93nH   0.68pF
2A   VSS   GND   91m   3.43nH   0.53pF
2B   VSSQ   GND   101m   3.53nH   0.72pF
2C   DQ3   dq   101m   3.40nH   0.70pF
2D   NC   NC   NA   NA   NA
2E   VSSQ   GND   94m   3.21nH   0.63pF
2F   DQ2   dq   93m   3.13nH   0.62pF
2G   NC   NC   NA   NA   NA
2H   VSS   GND   89m   3.07nH   0.53pF
2J   DQM   input2   90m   2.93nH   0.55pF
2K   CLK   input_clk   94m   3.13nH   0.60pF
2L   CKE   input2   103m   3.52nH   0.69pF
2M   A9   input   107m   3.60nH   0.75pF
2N   A7   input   109m   3.73nH   0.72pF
2P   A5   input   108m   3.78nH   0.70pF
2Q   VSS   GND   105m   3.89nH   0.56pF
7A   VDD   POWER   95m   3.52nH   0.58pF
7B   VDDQ   POWER   102m   3.50nH   0.77pF
7C   DQ0   dq   100m   3.29nH   0.65pF
7D   NC   NC   NA   NA   NA
7E   VDDQ   POWER   93m   3.15nH   0.61pF
7F   DQ1   dq   92m   2.95nH   0.62pF
7G   NC   NC   NA   NA   NA
7H   VDD   POWER   91m   3.08nH   0.57pF
7J   WE#   input_we   91m   3.04nH   0.61pF
7K   RAS#   input   93m   3.08nH   0.62pF
7L   NC   NC   NA   NA   NA
7M   BA1   input   100m   3.30nH   0.67pF
7N   A0   input   104m   3.42nH   0.70pF
7P   A2   input   110m   3.63nH   0.74pF
7Q   VDD   POWER   109m   4.03nH   0.60pF
8A   NC   NC   NA   NA   NA
8B   NC   NC   NA   NA   NA
8C   VSSQ   GND   112m   4.07nH   0.64pF
8D   NC   NC   NA   NA   NA
8E   NC   NC   NA   NA   NA
8F   VSSQ   GND   107m   3.81nH   0.62pF
8G   NC   NC   NA   NA   NA
8H   NC   NC   NA   NA   NA
8J   CAS#   input   108m   3.88nH   0.60pF
8K   NC   NC   NA   NA   NA
8L   CS#   input2   111m   3.95nH   0.63pF
8M   BA0   input   113m   4.00nH   0.65pF
8N   A10   input   117m   4.52nH   0.68pF
8P   A1   input   122m   4.42nH   0.70pF
8Q   A3   input   121m   4.74nH   0.73pF
| Models and submodels in the file (5): dq (I/O), input (Input), input2 (Input), input_clk (Input), input_we (Input)
