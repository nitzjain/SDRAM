| y15w.ibs * IBIS 3.2 Model
| 128Mb SDRAM - Die Revision "G"
|  Part Number   VDD/VDDQ   Architecture   Package
| MT48LC32M4A2TG   3.3V/3.3V   32 Meg x 4   54-pin TSOP II (400 mil)
| MT48LC32M4A2FC   3.3V/3.3V   32 Meg x 4   60-ball FBGA (11mm x 13mm)
| MT48LC32M4A2FB   3.3V/3.3V   32 Meg x 4   60-ball FBGA (8mm x 16mm)
| MT48LC16M8A2TG   3.3V/3.3V   16 Meg x 8   54-pin TSOP II (400 mil)
| MT48LC16M8A2FC   3.3V/3.3V   16 Meg x 8   60-ball FBGA (11mm x 13mm)
| MT48LC16M8A2FB   3.3V/3.3V   16 Meg x 8   60-ball FBGA (8mm x 16mm)
| MT48LC8M16A2TG   3.3V/3.3V   8 Meg x 16   54-pin TSOP II (400 mil)
| MT48LC8M16A2F4   3.3V/3.3V   8 Meg x 16   54-ball VFBGA (8mm x 8mm)
[IBIS Ver]   3.2
[File name]   y15w.ibs
[File rev]   2.2
[Date]   05/13/2005
[Source]   From silicon level SPICE model at Micron Technology, Inc.
   Micron Technology, Inc.
   8000 S. Federal Way
   P.O. Box 6   Mail Stop 01-711
   Boise ID 83707-0006
[Notes]   Rev 1.0: 09/03/2003
   - initial file creation
   Rev 2.0: 03/14/2004
   - updated all models to match latest silicon measurements
   - updated C_comp values for all models
   Rev 2.1: 04/27/2005
   - updated 54-lead TSOP package parasitics
   Rev 2.2: 05/13/2005
   - added 54-ball x16 VFBGA package
[Disclaimer]  This software code and all associated documentation, comments
              or other information (collectively "Software") is provided
              "AS IS" without warranty of any kind. MICRON TECHNOLOGY, INC.
              ("MTI") EXPRESSLY DISCLAIMS ALL WARRANTIES EXPRESS OR IMPLIED,
              INCLUDING BUT NOT LIMITED TO, NONINFRINGEMENT OF THIRD PARTY
              RIGHTS, AND ANY IMPLIED WARRANTIES OF MERCHANTABILITY OR FITNESS
              FOR ANY PARTICULAR PURPOSE. MTI DOES NOT WARRANT THAT THE
              SOFTWARE WILL MEET YOUR REQUIREMENTS, OR THAT THE OPERATION OF
              THE SOFTWARE WILL BE UNINTERRUPTED OR ERROR-FREE. FURTHERMORE,
              MTI DOES NOT MAKE ANY REPRESENTATIONS REGARDING THE USE OR THE
              RESULTS OF THE USE OF THE SOFTWARE IN TERMS OF ITS CORRECTNESS,
              ACCURACY, RELIABILITY, OR OTHERWISE. THE ENTIRE RISK ARISING OUT
              OF USE OR PERFORMANCE OF THE SOFTWARE REMAINS WITH YOU. IN NO
              EVENT SHALL MTI, ITS AFFILIATED COMPANIES OR THEIR SUPPLIERS BE
              LIABLE FOR ANY DIRECT, INDIRECT, CONSEQUENTIAL, INCIDENTAL, OR
              SPECIAL DAMAGES (INCLUDING, WITHOUT LIMITATION, DAMAGES FOR LOSS
              OF PROFITS, BUSINESS INTERRUPTION, OR LOSS OF INFORMATION)
              ARISING OUT OF YOUR USE OF OR INABILITY TO USE THE SOFTWARE,
              EVEN IF MTI HAS BEEN ADVISED OF THE POSSIBILITY OF SUCH DAMAGES.
              Because some jurisdictions prohibit the exclusion or limitation
              of liability for consequential or incidental damages, the above
              limitation may not apply to you.
[Copyright]   Copyright 2003 Micron Technology, Inc. All Rights Reserved.
|   COMPONENT: MT48LC32M4A2TG
[Component]   MT48LC32M4A2TG
[Manufacturer]   Micron Technology, Inc.
[Package]   | 54-pin TSOP
| variable   typ   min   max
R_pkg   191.8m   57.5m   240.6m
L_pkg   6.16nH   2.83nH   7.21nH
C_pkg   1.28pF   0.59pF   1.51pF
[Pin]  signal_name   model_name  R_pin   L_pin   C_pin
1   VDD   POWER   229.7m   9.45nH   1.85pF
2   NC   NC
3   VDDQ   POWER   178.4m   8.05nH   1.70pF
4   NC   NC
5   DQ0   dqbuff   162.1m   6.60nH   1.40pF
6   VSSQ   GND   217.2m   6.09nH   1.26pF
7   NC   NC
8   NC   NC
9   VDDQ   POWER   78.8m   3.97nH   0.78pF
10   NC   NC
11   DQ1   dqbuff   57.5m   2.83nH   0.60pF
12   VSSQ   GND   41.9m   2.28nH   0.51pF
13   NC   NC
14   VDD   POWER   8.7m   1.20nH   0.35pF
15   NC   NC
16   WE#   inbuff2   199.8m   5.41nH   1.11pF
17   CAS#   inbuff   180.0m   5.19nH   1.16pF
18   RAS#   inbuff   206.4m   5.74nH   1.17pF
19   CS#   inbuff3   203.7m   6.20nH   1.24pF
20   BA0   inbuff   211.3m   6.40nH   1.25pF
21   BA1   inbuff   236.2m   6.93nH   1.33pF
22   A10   inbuff   222.4m   6.78nH   1.37pF
23   A0   inbuff   223.5m   6.81nH   1.42pF
24   A1   inbuff   240.6m   7.21nH   1.38pF
25   A2   inbuff   199.8m   7.02nH   1.44pF
26   A3   inbuff   156.0m   7.04nH   1.46pF
27   VDD   POWER   148.2m   4.92nH   1.63pF
28   VSS   GND   148.2m   4.92nH   1.63pF
29   A4   inbuff   156.0m   7.04nH   1.49pF
30   A5   inbuff   199.8m   7.02nH   1.48pF
31   A6   inbuff   240.6m   7.21nH   1.47pF
32   A7   inbuff   223.5m   6.81nH   1.51pF
33   A8   inbuff   222.4m   6.78nH   1.49pF
34   A9   inbuff   236.2m   6.93nH   1.37pF
35   A11   inbuff   211.3m   6.40nH   1.33pF
36   NC   NC
37   CKE   inbuff3   206.4m   5.74nH   1.24pF
38   CLK   clkbuff   180.0m   5.19nH   1.17pF
39   DQM   inbuff3   199.8m   5.41nH   1.13pF
40   NC   NC
41   VSS   GND   17.4m   1.46nH   0.40pF
42   NC   NC
43   VDDQ   POWER   41.9m   2.28nH   0.52pF
44   DQ2   dqbuff   57.5m   2.83nH   0.59pF
45   NC   NC
46   VSSQ   GND   78.8m   3.97nH   0.78pF
47   NC   NC
48   NC   NC
49   VDDQ   POWER   217.2m   6.09nH   1.26pF
50   DQ3   dqbuff   162.1m   6.60nH   1.41pF
51   NC   NC
52   VSSQ   GND   178.4m   8.05nH   1.70pF
53   NC   NC
54   VSS   GND   229.7m   9.45nH   1.85pF
|   COMPONENT: MT48LC32M4A2FC
[Component]   MT48LC32M4A2FC
[Manufacturer]   Micron Technology, Inc.
[Package]   | 60-ball FBGA
| variable   typ   min   max
R_pkg   180.2m   105.8m   254.7m
L_pkg   5.24nH   3.58nH   6.89nH
C_pkg   1.23pF   0.90pF   1.56pF
[Pin]  signal_name   model_name  R_pin   L_pin   C_pin
A1   NC   NC
A2   VSS   GND   64.35m   2.46nH   5.84pF
A7   VDD   POWER   71.86m   2.76nH   7.39pF
A8   NC   NC
B1   NC   NC
B2   VSSQ   GND   64.35m   2.46nH   5.84pF
B7   VDDQ   POWER   86.44m   2.16nH   5.74pF
B8   NC   NC
C1   VDDQ   POWER   86.44m   2.16nH   5.74pF
C2   DQ3   dqbuff   108.2m   3.71nH   1.07pF
C7   DQ0   dqbuff   105.8m   3.58nH   1.17pF
C8   VSSQ   GND   64.35m   2.46nH   5.84pF
D1   NC   NC
D2   NC   NC
D7   NC   NC
D8   NC   NC
E1   NC   NC
E2   VSSQ   GND   64.35m   2.46nH   5.84pF
E7   VDDQ   POWER   86.44m   2.16nH   5.74pF
E8   NC   NC
F1   VDDQ   POWER   86.44m   2.16nH   5.74pF
F2   DQ2   dqbuff   147.5m   4.40nH   1.36pF
F7   DQ1   dqbuff   170.6m   5.76nH   1.42pF
F8   VSSQ   GND   64.35m   2.46nH   5.84pF
G1   NC   NC
G2   NC   NC
G7   NC   NC
G8   NC   NC
H1   NC   NC
H2   VSS   GND   64.35m   2.46nH   5.84pF
H7   VDD   POWER   71.86m   2.76nH   7.39pF
H8   NC   NC
J1   NC   NC
J2   DQM   inbuff3   228.7m   5.58nH   1.25pF
J7   WE#   inbuff2   221.2m   5.25nH   1.25pF
J8   CAS#   inbuff   211.9m   5.04nH   1.20pF
K1   NC   NC
K2   CK   clkbuff   225.8m   5.19nH   1.33pF
K7   RAS#   inbuff   224.7m   5.58nH   1.31pF
K8   NC   NC
L1   NC   NC
L2   CKE   inbuff3   221.7m   5.26nH   1.25pF
L7   NC   NC
L8   CS#   inbuff3   212.1m   5.37nH   1.18pF
M1   A11   inbuff   112.6m   4.95nH   0.99pF
M2   A9   inbuff   244.3m   6.42nH   1.46pF
M7   BA1   inbuff   205.4m   5.02nH   1.15pF
M8   BA0   inbuff   237.5m   6.31nH   1.31pF
N1   A8   inbuff   236.6m   5.80nH   1.36pF
N2   A7   inbuff   242.9m   6.87nH   1.33pF
N7   A0   inbuff   196.3m   5.67nH   0.90pF
N8   A10   inbuff   254.7m   6.53nH   1.56pF
P1   A6   inbuff   228.9m   5.99nH   1.13pF
P2   A5   inbuff   244.7m   6.81nH   1.31pF
P7   A2   inbuff   242.3m   6.89nH   1.30pF
P8   A1   inbuff   224.4m   5.87nH   1.12pF
R1   A4   inbuff   231.9m   5.92nH   1.21pF
R2   VSS   GND   64.35m   2.46nH   5.84pF
R7   VDD   POWER   71.86m   2.76nH   7.39pF
R8   A3   inbuff   239.9m   6.21nH   1.21pF
|   COMPONENT: MT48LC32M4A2FB
[Component]   MT48LC32M4A2FB
[Manufacturer]   Micron Technology, Inc.
[Package]   | 60-ball FBGA
| variable   typ   min   max
R_pkg   180.2m   105.8m   254.7m
L_pkg   5.24nH   3.58nH   6.89nH
C_pkg   1.23pF   0.90pF   1.56pF
[Pin]  signal_name   model_name  R_pin   L_pin   C_pin
A1   NC   NC
A2   VSS   GND   64.35m   2.46nH   5.84pF
A7   VDD   POWER   71.86m   2.76nH   7.39pF
A8   NC   NC
B1   NC   NC
B2   VSSQ   GND   64.35m   2.46nH   5.84pF
B7   VDDQ   POWER   86.44m   2.16nH   5.74pF
B8   NC   NC
C1   VDDQ   POWER   86.44m   2.16nH   5.74pF
C2   DQ3   dqbuff   108.2m   3.71nH   1.07pF
C7   DQ0   dqbuff   105.8m   3.58nH   1.17pF
C8   VSSQ   GND   64.35m   2.46nH   5.84pF
D1   NC   NC
D2   NC   NC
D7   NC   NC
D8   NC   NC
E1   NC   NC
E2   VSSQ   GND   64.35m   2.46nH   5.84pF
E7   VDDQ   POWER   86.44m   2.16nH   5.74pF
E8   NC   NC
F1   VDDQ   POWER   86.44m   2.16nH   5.74pF
F2   DQ2   dqbuff   147.5m   4.40nH   1.36pF
F7   DQ1   dqbuff   170.6m   5.76nH   1.42pF
F8   VSSQ   GND   64.35m   2.46nH   5.84pF
G1   NC   NC
G2   NC   NC
G7   NC   NC
G8   NC   NC
H1   NC   NC
H2   VSS   GND   64.35m   2.46nH   5.84pF
H7   VDD   POWER   71.86m   2.76nH   7.39pF
H8   NC   NC
J1   NC   NC
J2   DQM   inbuff3   228.7m   5.58nH   1.25pF
J7   WE#   inbuff2   221.2m   5.25nH   1.25pF
J8   CAS#   inbuff   211.9m   5.04nH   1.20pF
K1   NC   NC
K2   CK   clkbuff   225.8m   5.19nH   1.33pF
K7   RAS#   inbuff   224.7m   5.58nH   1.31pF
K8   NC   NC
L1   NC   NC
L2   CKE   inbuff3   221.7m   5.26nH   1.25pF
L7   NC   NC
L8   CS#   inbuff3   212.1m   5.37nH   1.18pF
M1   A11   inbuff   112.6m   4.95nH   0.99pF
M2   A9   inbuff   244.3m   6.42nH   1.46pF
M7   BA1   inbuff   205.4m   5.02nH   1.15pF
M8   BA0   inbuff   237.5m   6.31nH   1.31pF
N1   A8   inbuff   236.6m   5.80nH   1.36pF
N2   A7   inbuff   242.9m   6.87nH   1.33pF
N7   A0   inbuff   196.3m   5.67nH   0.90pF
N8   A10   inbuff   254.7m   6.53nH   1.56pF
P1   A6   inbuff   228.9m   5.99nH   1.13pF
P2   A5   inbuff   244.7m   6.81nH   1.31pF
P7   A2   inbuff   242.3m   6.89nH   1.30pF
P8   A1   inbuff   224.4m   5.87nH   1.12pF
R1   A4   inbuff   231.9m   5.92nH   1.21pF
R2   VSS   GND   64.35m   2.46nH   5.84pF
R7   VDD   POWER   71.86m   2.76nH   7.39pF
R8   A3   inbuff   239.9m   6.21nH   1.21pF
|   COMPONENT: MT48LC16M8A2TG
[Component]   MT48LC16M8A2TG
[Manufacturer]   Micron Technology, Inc.
[Package]   | 54-pin TSOP
| variable   typ   min   max
R_pkg   192.7m   57.5m   240.6m
L_pkg   6.18nH   2.83nH   7.32nH
C_pkg   1.30pF   0.59pF   1.84pF
[Pin]  signal_name   model_name  R_pin   L_pin   C_pin
1   VDD   POWER   229.7m   9.45nH   1.85pF
2   DQ0   dqbuff   229.8m   7.32nH   1.84pF
3   VDDQ   POWER   178.4m   8.05nH   1.70pF
4   NC   NC
5   DQ1   dqbuff   162.1m   6.60nH   1.40pF
6   VSSQ   GND   217.2m   6.09nH   1.26pF
7   NC   NC
8   DQ2   dqbuff   167.3m   5.22nH   0.97pF
9   VDDQ   POWER   78.8m   3.97nH   0.78pF
10   NC   NC
11   DQ3   dqbuff   57.5m   2.83nH   0.60pF
12   VSSQ   GND   41.9m   2.28nH   0.51pF
13   NC   NC
14   VDD   POWER   8.7m   1.20nH   0.35pF
15   NC   NC
16   WE#   inbuff2   199.8m   5.41nH   1.11pF
17   CAS#   inbuff   180.0m   5.19nH   1.16pF
18   RAS#   inbuff   206.4m   5.74nH   1.17pF
19   CS#   inbuff3   203.7m   6.20nH   1.24pF
20   BA0   inbuff   211.3m   6.40nH   1.25pF
21   BA1   inbuff   236.2m   6.93nH   1.33pF
22   A10   inbuff   222.4m   6.78nH   1.37pF
23   A0   inbuff   223.5m   6.81nH   1.42pF
24   A1   inbuff   240.6m   7.21nH   1.38pF
25   A2   inbuff   199.8m   7.02nH   1.44pF
26   A3   inbuff   156.0m   7.04nH   1.46pF
27   VDD   POWER   148.2m   4.92nH   1.63pF
28   VSS   GND   148.2m   4.92nH   1.63pF
29   A4   inbuff   156.0m   7.04nH   1.49pF
30   A5   inbuff   199.8m   7.02nH   1.48pF
31   A6   inbuff   240.6m   7.21nH   1.47pF
32   A7   inbuff   223.5m   6.81nH   1.51pF
33   A8   inbuff   222.4m   6.78nH   1.49pF
34   A9   inbuff   236.2m   6.93nH   1.37pF
35   A11   inbuff   211.3m   6.40nH   1.33pF
36   NC   NC
37   CKE   inbuff3   206.4m   5.74nH   1.24pF
38   CLK   clkbuff   180.0m   5.19nH   1.17pF
39   DQM   inbuff3   199.8m   5.41nH   1.13pF
40   NC   NC
41   VSS   GND   17.4m   1.46nH   0.40pF
42   NC   NC
43   VDDQ   POWER   41.9m   2.28nH   0.52pF
44   DQ4   dqbuff   57.5m   2.83nH   0.59pF
45   NC   NC
46   VSSQ   GND   78.8m   3.97nH   0.78pF
47   DQ5   dqbuff   167.3m   5.22nH   0.97pF
48   NC   NC
49   VDDQ   POWER   217.2m   6.09nH   1.26pF
50   DQ6   dqbuff   162.1m   6.60nH   1.41pF
51   NC   NC
52   VSSQ   GND   178.4m   8.05nH   1.70pF
53   DQ7   dqbuff   229.8m   7.32nH   1.84pF
54   VSS   GND   229.7m   9.45nH   1.85pF
|   COMPONENT: MT48LC16M8A2FC
[Component]   MT48LC16M8A2FC
[Manufacturer]   Micron Technology, Inc.
[Package]   | 60-ball FBGA
| variable   typ   min   max
R_pkg   180.2m   105.8m   254.7m
L_pkg   5.40nH   3.58nH   7.22nH
C_pkg   1.37pF   0.90pF   1.84pF
[Pin]  signal_name   model_name  R_pin   L_pin   C_pin
A1   DQ7   dqbuff   230.5m   6.61nH   1.52pF
A2   VSS   GND   64.35m   2.46nH   5.84pF
A7   VDD   POWER   71.86m   2.76nH   7.39pF
A8   DQ0   dqbuff   201.9m   7.22nH   1.48pF
B1   NC   NC
B2   VSSQ   GND   64.35m   2.46nH   5.84pF
B7   VDDQ   POWER   86.44m   2.16nH   5.74pF
B8   NC   NC
C1   VDDQ   POWER   86.44m   2.16nH   5.74pF
C2   DQ6   dqbuff   108.2m   3.71nH   1.07pF
C7   DQ1   dqbuff   105.8m   3.58nH   1.17pF
C8   VSSQ   GND   64.35m   2.46nH   5.84pF
D1   DQ5   dqbuff   164.1m   5.68nH   1.45pF
D2   NC   NC
D7   NC   NC
D8   DQ2   dqbuff   172.3m   5.73nH   1.84pF
E1   NC   NC
E2   VSSQ   GND   64.35m   2.46nH   5.84pF
E7   VDDQ   POWER   86.44m   2.16nH   5.74pF
E8   NC   NC
F1   VDDQ   POWER   86.44m   2.16nH   5.74pF
F2   DQ4   dqbuff   147.5m   4.40nH   1.36pF
F7   DQ3   dqbuff   170.6m   5.76nH   1.42pF
F8   VSSQ   GND   64.35m   2.46nH   5.84pF
G1   NC   NC
G2   NC   NC
G7   NC   NC
G8   NC   NC
H1   NC   NC
H2   VSS   GND   64.35m   2.46nH   5.84pF
H7   VDD   POWER   71.86m   2.76nH   7.39pF
H8   NC   NC
J1   NC   NC
J2   DQM   inbuff3   228.7m   5.58nH   1.25pF
J7   WE#   inbuff2   221.2m   5.25nH   1.25pF
J8   CAS#   inbuff   211.9m   5.04nH   1.20pF
K1   NC   NC
K2   CK   clkbuff   225.8m   5.19nH   1.33pF
K7   RAS#   inbuff   224.7m   5.58nH   1.31pF
K8   NC   NC
L1   NC   NC
L2   CKE   inbuff3   221.7m   5.26nH   1.25pF
L7   NC   NC
L8   CS#   inbuff3   212.1m   5.37nH   1.18pF
M1   A11   inbuff   112.6m   4.95nH   0.99pF
M2   A9   inbuff   244.3m   6.42nH   1.46pF
M7   BA1   inbuff   205.4m   5.02nH   1.15pF
M8   BA0   inbuff   237.5m   6.31nH   1.31pF
N1   A8   inbuff   236.6m   5.80nH   1.36pF
N2   A7   inbuff   242.9m   6.87nH   1.33pF
N7   A0   inbuff   196.3m   5.67nH   0.90pF
N8   A10   inbuff   254.7m   6.53nH   1.56pF
P1   A6   inbuff   228.9m   5.99nH   1.13pF
P2   A5   inbuff   244.7m   6.81nH   1.31pF
P7   A2   inbuff   242.3m   6.89nH   1.30pF
P8   A1   inbuff   224.4m   5.87nH   1.12pF
R1   A4   inbuff   231.9m   5.92nH   1.21pF
R2   VSS   GND   64.35m   2.46nH   5.84pF
R7   VDD   POWER   71.86m   2.76nH   7.39pF
R8   A3   inbuff   239.9m   6.21nH   1.21pF
|   COMPONENT: MT48LC16M8A2FB
[Component]   MT48LC16M8A2FB
[Manufacturer]   Micron Technology, Inc.
[Package]   | 60-ball FBGA
| variable   typ   min   max
R_pkg   180.2m   105.8m   254.7m
L_pkg   5.40nH   3.58nH   7.22nH
C_pkg   1.37pF   0.90pF   1.84pF
[Pin]  signal_name   model_name  R_pin   L_pin   C_pin
A1   DQ7   dqbuff   230.5m   6.61nH   1.52pF
A2   VSS   GND   64.35m   2.46nH   5.84pF
A7   VDD   POWER   71.86m   2.76nH   7.39pF
A8   DQ0   dqbuff   201.9m   7.22nH   1.48pF
B1   NC   NC
B2   VSSQ   GND   64.35m   2.46nH   5.84pF
B7   VDDQ   POWER   86.44m   2.16nH   5.74pF
B8   NC   NC
C1   VDDQ   POWER   86.44m   2.16nH   5.74pF
C2   DQ6   dqbuff   108.2m   3.71nH   1.07pF
C7   DQ1   dqbuff   105.8m   3.58nH   1.17pF
C8   VSSQ   GND   64.35m   2.46nH   5.84pF
D1   DQ5   dqbuff   164.1m   5.68nH   1.45pF
D2   NC   NC
D7   NC   NC
D8   DQ2   dqbuff   172.3m   5.73nH   1.84pF
E1   NC   NC
E2   VSSQ   GND   64.35m   2.46nH   5.84pF
E7   VDDQ   POWER   86.44m   2.16nH   5.74pF
E8   NC   NC
F1   VDDQ   POWER   86.44m   2.16nH   5.74pF
F2   DQ4   dqbuff   147.5m   4.40nH   1.36pF
F7   DQ3   dqbuff   170.6m   5.76nH   1.42pF
F8   VSSQ   GND   64.35m   2.46nH   5.84pF
G1   NC   NC
G2   NC   NC
G7   NC   NC
G8   NC   NC
H1   NC   NC
H2   VSS   GND   64.35m   2.46nH   5.84pF
H7   VDD   POWER   71.86m   2.76nH   7.39pF
H8   NC   NC
J1   NC   NC
J2   DQM   inbuff3   228.7m   5.58nH   1.25pF
J7   WE#   inbuff2   221.2m   5.25nH   1.25pF
J8   CAS#   inbuff   211.9m   5.04nH   1.20pF
K1   NC   NC
K2   CK   clkbuff   225.8m   5.19nH   1.33pF
K7   RAS#   inbuff   224.7m   5.58nH   1.31pF
K8   NC   NC
L1   NC   NC
L2   CKE   inbuff3   221.7m   5.26nH   1.25pF
L7   NC   NC
L8   CS#   inbuff3   212.1m   5.37nH   1.18pF
M1   A11   inbuff   112.6m   4.95nH   0.99pF
M2   A9   inbuff   244.3m   6.42nH   1.46pF
M7   BA1   inbuff   205.4m   5.02nH   1.15pF
M8   BA0   inbuff   237.5m   6.31nH   1.31pF
N1   A8   inbuff   236.6m   5.80nH   1.36pF
N2   A7   inbuff   242.9m   6.87nH   1.33pF
N7   A0   inbuff   196.3m   5.67nH   0.90pF
N8   A10   inbuff   254.7m   6.53nH   1.56pF
P1   A6   inbuff   228.9m   5.99nH   1.13pF
P2   A5   inbuff   244.7m   6.81nH   1.31pF
P7   A2   inbuff   242.3m   6.89nH   1.30pF
P8   A1   inbuff   224.4m   5.87nH   1.12pF
R1   A4   inbuff   231.9m   5.92nH   1.21pF
R2   VSS   GND   64.35m   2.46nH   5.84pF
R7   VDD   POWER   71.86m   2.76nH   7.39pF
R8   A3   inbuff   239.9m   6.21nH   1.21pF
|   COMPONENT: MT48LC8M16A2TG
[Component]   MT48LC8M16A2TG
[Manufacturer]   Micron Technology, Inc.
[Package]   | 54-pin TSOP
| variable   typ   min   max
R_pkg   184.4m   57.5m   240.6m
L_pkg   5.95nH   2.83nH   7.32nH
C_pkg   1.25pF   0.59pF   1.84pF
[Pin]  signal_name   model_name  R_pin   L_pin   C_pin
1   VDD   POWER   229.7m   9.45nH   1.85pF
2   DQ0   dqbuff   229.8m   7.32nH   1.84pF
3   VDDQ   POWER   178.4m   8.05nH   1.70pF
4   DQ1   dqbuff   142.1m   7.27nH   1.55pF
5   DQ2   dqbuff   162.1m   6.60nH   1.40pF
6   VSSQ   GND   217.2m   6.09nH   1.26pF
7   DQ3   dqbuff   225.7m   5.92nH   1.11pF
8   DQ4   dqbuff   167.3m   5.22nH   0.97pF
9   VDDQ   POWER   78.8m   3.97nH   0.78pF
10   DQ5   dqbuff   68.3m   3.30nH   0.64pF
11   DQ6   dqbuff   57.5m   2.83nH   0.60pF
12   VSSQ   GND   41.9m   2.28nH   0.51pF
13   DQ7   dqbuff   162.6m   4.43nH   1.04pF
14   VDD   POWER   8.7m   1.20nH   0.35pF
15   DQML   inbuff3   222.4m   4.98nH   1.08pF
16   WE#   inbuff2   199.8m   5.41nH   1.11pF
17   CAS#   inbuff   180.0m   5.19nH   1.16pF
18   RAS#   inbuff   206.4m   5.74nH   1.17pF
19   CS#   inbuff3   203.7m   6.20nH   1.24pF
20   BA0   inbuff   211.3m   6.40nH   1.25pF
21   BA1   inbuff   236.2m   6.93nH   1.33pF
22   A10   inbuff   222.4m   6.78nH   1.37pF
23   A0   inbuff   223.5m   6.81nH   1.42pF
24   A1   inbuff   240.6m   7.21nH   1.38pF
25   A2   inbuff   199.8m   7.02nH   1.44pF
26   A3   inbuff   156.0m   7.04nH   1.46pF
27   VDD   POWER   148.2m   4.92nH   1.63pF
28   VSS   GND   148.2m   4.92nH   1.63pF
29   A4   inbuff   156.0m   7.04nH   1.49pF
30   A5   inbuff   199.8m   7.02nH   1.48pF
31   A6   inbuff   240.6m   7.21nH   1.47pF
32   A7   inbuff   223.5m   6.81nH   1.51pF
33   A8   inbuff   222.4m   6.78nH   1.49pF
34   A9   inbuff   236.2m   6.93nH   1.37pF
35   A11   inbuff   211.3m   6.40nH   1.33pF
36   NC   NC
37   CKE   inbuff3   206.4m   5.74nH   1.24pF
38   CLK   clkbuff   180.0m   5.19nH   1.17pF
39   DQMH   inbuff3   199.8m   5.41nH   1.13pF
40   NC   NC
41   VSS   GND   17.4m   1.46nH   0.40pF
42   DQ8   dqbuff   162.6m   4.43nH   1.04pF
43   VDDQ   POWER   41.9m   2.28nH   0.52pF
44   DQ9   dqbuff   57.5m   2.83nH   0.59pF
45   DQ10   dqbuff   68.3m   3.30nH   0.64pF
46   VSSQ   GND   78.8m   3.97nH   0.78pF
47   DQ11   dqbuff   167.3m   5.22nH   0.97pF
48   DQ12   dqbuff   225.7m   5.92nH   1.11pF
49   VDDQ   POWER   217.2m   6.09nH   1.26pF
50   DQ13   dqbuff   162.1m   6.60nH   1.41pF
51   DQ14   dqbuff   142.1m   7.27nH   1.55pF
52   VSSQ   GND   178.4m   8.05nH   1.70pF
53   DQ15   dqbuff   229.8m   7.32nH   1.84pF
54   VSS   GND   229.7m   9.45nH   1.85pF
|   COMPONENT: MT48LC8M16A2F4 SDRAM
[Component]   MT48LC8M16A2F4
[Manufacturer]   Micron Technology Inc.
[Package]   | 54-ball VFBGA
| variable   typ   min   max
R_pkg   100.6m   8.982m   192.3m
L_pkg   4.72nH   1.24nH   8.19nH
C_pkg   0.84pF   0.27pF   1.42pF
[Pin]  signal_name   model_name  R_pin   L_pin   C_pin
A1   VSS   GND   23.98m   0.80nH   7.62pF
A2   DQ15   dqbuff   192.3m   8.19nH   1.42pF
A3   VSSQ   GND   59.00m   2.53nH   0.45pF
A7   VDDQ   POWER   62.56m   2.32nH   0.34pF
A8   DQ0   dqbuff   126.6m   5.34nH   0.98pF
A9   VDD   POWER   47.45m   2.13nH   2.44pF
B1   DQ14   dqbuff   92.76m   3.88nH   0.82pF
B2   DQ13   dqbuff   83.43m   3.66nH   1.06pF
B3   VDDQ   POWER   83.32m   3.06nH   0.45pF
B7   VSSQ   GND   15.94m   0.50nH   0.77pF
B8   DQ2   dqbuff   99.97m   4.41nH   0.84pF
B9   DQ1   dqbuff   101.8m   3.98nH   0.82pF
C1   DQ12   dqbuff   192.2m   7.86nH   1.40pF
C2   DQ11   dqbuff   100.8m   4.40nH   0.83pF
C3   VSSQ   GND   29.39m   2.14nH   0.59pF
C7   VDDQ   POWER   42.02m   1.43nH   0.77pF
C8   DQ4   dqbuff   106.6m   3.82nH   0.89pF
C9   DQ3   dqbuff   109.4m   4.76nH   0.90pF
D1   DQ10   dqbuff   19.70m   1.29nH   0.33pF
D2   DQ9   dqbuff   34.12m   1.89nH   0.40pF
D3   VDDQ   POWER   84.26m   3.55nH   0.56pF
D7   VSSQ   GND   35.43m   1.71nH   0.36pF
D8   DQ6   dqbuff   34.82m   1.72nH   0.42pF
D9   DQ5   dqbuff   18.00m   1.24nH   0.37pF
E1   DQ8   dqbuff   13.04m   3.85nH   0.33pF
E2   NC   NC
E3   VSS   GND   23.98m   0.80nH   7.62pF
E7   VDD   POWER   47.45m   2.13nH   2.44pF
E8   LDQM   inbuff3   80.09m   6.31nH   0.72pF
E9   DQ7   dqbuff   8.982m   3.63nH   0.27pF
F1   UDQM   inbuff3   119.9m   7.77nH   0.95pF
F2   CLK   clkbuff   92.98m   6.67nH   0.85pF
F3   CKE   inbuff3   57.52m   5.79nH   0.65pF
F7   CAS#   inbuff   70.45m   6.19nH   0.63pF
F8   RAS#   inbuff   56.38m   5.77nH   0.59pF
F9   WE#   inbuff2   124.5m   4.89nH   0.99pF
G1   NC   NC
G2   A11   inbuff   100.6m   6.63nH   0.91pF
G3   A9   inbuff   57.53m   5.47nH   0.65pF
G7   BA0   inbuff   86.92m   6.26nH   0.73pF
G8   BA1   inbuff   49.54m   5.09nH   0.54pF
G9   CS#   inbuff3   62.91m   5.95nH   0.56pF
H1   A8   inbuff   55.16m   5.61nH   0.64pF
H2   A7   inbuff   91.47m   6.27nH   0.85pF
H3   A6   inbuff   52.52m   5.18nH   0.60pF
H7   A0   inbuff   63.48m   5.61nH   0.63pF
H8   A1   inbuff   63.80m   5.23nH   0.62pF
H9   A10   inbuff   85.17m   6.04nH   0.76pF
J1   VSS   GND   23.98m   0.80nH   7.62pF
J2   A5   inbuff   53.64m   5.13nH   0.64pF
J3   A4   inbuff   35.54m   4.59nH   0.52pF
J7   A3   inbuff   64.75m   5.50nH   0.63pF
J8   A2   inbuff   33.99m   4.75nH   0.45pF
J9   VDD   POWER   47.45m   2.13nH   2.44pF
| Models and submodels in the file (5): dqbuff (I/O), clkbuff (Input), inbuff (Input), inbuff2 (Input), inbuff3 (Input)
